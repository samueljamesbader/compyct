`include "disciplines.vams"
`include "constants.vams"

`define IPRco(nam,def,uni,lwr,upr,des) (*units=uni, type="instance",  desc=des*) parameter real    nam=def from[lwr:upr);
`define MPRco(nam,def,uni,lwr,upr,des) (*units=uni,                   desc=des*) parameter real    nam=def from[lwr:upr);
`define MPRoz(nam,def,uni,        des) (*units=uni,                   desc=des*) parameter real    nam=def from(  0:inf);

module trivial_xtor(d,g,s,b);
    inout d,g,s,b;
    electrical d,g,s,b;
    //electrical trap;

    `IPRco(  l,   5e-6,      "m",    1e-6,    inf,    "Channel length" )
    `IPRco(  w,   1e-6,      "m",    1e-6,    inf,    "Channel width" )
    `MPRco(  n,    1.5,       "",       1,    inf,    "Subthreshold ideality factor" )
    `MPRoz( cg,   1e-3,  "F/m^2",                     "Gate capacitance per area" )
    `MPRoz( u0,   1,     "m^2/Vs",                     "Low-field mobility" )
    `MPRoz( vs,   1e+5,    "m/s",                     "Saturation velocity" )
    `MPRoz( vt0,   0.5,      "V",                     "Threshold voltage" )

    real vth, qg_oA, qg, qd, qs, beta, vu, v, rsb;
analog begin
    vth =`P_K * $temperature / `P_Q;
    qg_oA = cg*ln(1+exp((V(g,s)-vt0)/(n*vth)));
    qg = w * l * qg_oA;
    qd = qg/2;
    qs = qg/2;

    beta=2;
    vu = u0 * V(d,s) / l;
    v = vu/pow((1+pow(vu/vs,beta)),1/beta);

    I(d,s) <+ w * qg_oA * v;
    I(g,s) <+ ddt(qs);
    I(g,d) <+ ddt(qd);

    rsb = 1;
    V(s,b) <+ I(s,b)*rsb;
end

endmodule
